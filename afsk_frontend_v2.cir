* SMC Audio-Jack Converter - Front End v0.2
* Using LM393-equivalent behavioral model (real datasheet characteristics,
* not an idealized comparator) since vendor .lib files aren't fetchable
* in this sandbox. Modeled from published LM393 specs:
*   - Open-collector output (NOT push-pull) -> REQUIRES pull-up resistor
*   - Input offset voltage: ~2mV typ, 5mV max -> ignorable here
*   - Propagation delay: ~1.3us typ (matters at AFSK rates, still plenty fast)
*   - Output saturation voltage (low): ~70mV typ at 4mA load
*   - Open-loop, NO internal hysteresis -> this matters, see note below

.title AFSK Front End v0.2 - LM393-realistic model

* --- Source: phone headphone-out ---
* Test BOTH AFSK tones in sequence to confirm clean discrimination:
* 0-2ms: silence (phone not transmitting) - tests noise immunity
* 2-7ms: 1200 Hz tone ("0" bit, Bell 202 space)
* 7-12ms: 2200 Hz tone ("1" bit, Bell 202 mark)
* Three tone generators, each gated to its own time window via a
* behavioral switch. This is more readable/forkable than a giant
* inline PWL point dump, and avoids file-include path issues.
Vtone1200 t1200 0 SIN(0 0.4 1200 0 0)
Vtone2200 t2200 0 SIN(0 0.4 2200 0 0)

* Gate control signals: high during their respective windows
Vgate1 g1 0 PWL(0 0  1.999m 0  2m 1  6.999m 1  7m 0  12m 0)
Vgate2 g2 0 PWL(0 0  6.999m 0  7m 1  11.999m 1  12m 0)

Sgate1 t1200 mix1 g1 0 SWMOD2
Sgate2 t2200 mix2 g2 0 SWMOD2
.model SWMOD2 SW(Ron=1 Roff=1Meg Vt=0.5)

Rmix1 mix1 sig 1
Rmix2 mix2 sig 1
Rterm sig 0 1Meg

Rsrc sig vin_node 32
Cin vin_node a_node 1u
Rbias1 vdd a_node 47k
Rbias2 a_node 0 47k
Rfilt a_node b_node 1k
Cfilt b_node 0 100n

Vdd vdd 0 3.3

* --- LM393 behavioral model WITH hysteresis ---
* The bare comparator above false-triggers on any noise sitting at
* the 1.65V threshold (silence = false bit transitions = could be
* misread as motor commands downstream - unacceptable).
* FIX: add positive feedback (Rfb) from output back to the comparator's
* reference node, creating a Schmitt trigger. This is the same fix
* real LM393 application circuits use (see TI app notes on Schmitt
* trigger comparators) - NOT a simulation-only patch.
*
* Hysteresis band set by Rfb/Rref ratio. Target: ~100mV deadband,
* enough to reject simulator/real-world noise but small enough to
* not eat into the ~400mV signal swing we expect from the phone.

* Schmitt trigger reference: thresh_node centers on 1.65V (matching
* the bias point) with hysteresis added via feedback from output.
* R1/R2 establish the 1.65V center; Rfb adds the hysteresis kick.
Rref1 vdd thresh_node 94k
Rref2 thresh_node 0 94k
Rfb out thresh_node 470k
* Hysteresis band ~= (parallel(Rref1,Rref2)/Rfb) * 3.3V, roughly 100mV -
* enough margin to reject noise/quantization without eating real signal.

Bdecide dec_node 0 V = {3.3 * (V(b_node) > V(thresh_node))}
Rdelay dec_node dec_lagged 1k
Cdelay dec_lagged 0 1.3n
* dec_lagged now lags ~1.3ns*1000=1.3us behind ideal decision - approximates tpd

* Open-collector output stage: switch pulls to GND when dec_lagged is high
* (LM393: output transistor saturates when V+ > V-, sinking current to GND)
Sout out 0 dec_lagged 0 SWMOD
.model SWMOD SW(Ron=70 Roff=1Meg Vt=1.65 Vh=0.1)

* --- REQUIRED external pull-up (open-collector needs this - common
* mistake when people skip it after seeing push-pull comparators) ---
Rpullup vdd out 4.7k

* MCU input load
Rload out 0 1Meg

.options TRTOL=1
.control
tran 5u 12m 0 5u
wrdata afsk_v2_output.txt V(sig) V(b_node) V(out)
.endc

.end
